//
//  junctionMacros.va
//
//  Version: 1.0.0, October 30, 2014
//
//  This software is distributed as is, completely without warranty, liability,
//  copyright, or service support. Users may use, modify, copy, and redistribute
//  the software and documentation, both within the user's organization and externally,
//  without restriction.
//
//  As a courtesy:
//  1. If you use this software, please make an appropriate acknowledgement.
//  2. If you correct a bug in the software or add an enhancement, feed the
//     correction or enhancement back, to help maintain an open-source,
//     useful, and high quality suite of general macros for everyone who
//     is writing a model in Verilog-A.
//

//
//  This file contains macro definitions for aspects of pn junctions:
//  - normalized depletion charge (derivative of which gives capacitance)
//  - junction current with area and perimeter components
//  - depletion charge with area and perimeter components
//  - simple breakdown
//  - built-in potential temperature mapping (that does not become negative at high T)
//  - junction shot noise, including ideal and nonideal components
//  As pn junctions, either intentional or parasitic, are found in many
//  semiconductor devices these macros can help simplify writing full
//  device level models by providing standard "building blocks" for
//  those junctions.
//
//  NOTE: macros that use local variables explicitly declare these, so no module
//        level variables have to be declared to use the macros. This makes the
//        macros stand-alone, but requires block names to passed as macro arguments
//        as local variables can only be declared in named blocks in Verilog-AMS.
//        The block names must be unique within a module.
//  NOTE: some compilers have not yet implemented the IEEE std 1364-2005
//        Verilog HDL style calls for mathematical functions; this is why
//         ln(),  log()  ,  exp(),  sqrt(),  pow(), etc. are used instead of
//        $ln(), $log10(), $exp(), $sqrt(), $pow(), etc.
//        (the second forms are those "encouraged" to be used since LRM2.3)
//

////////////////////////////////////////////////////////////////////////////////
////////////////////////////////////////////////////////////////////////////////
//
//  Basic normalized depletion charge models, that include the standard
//  regional SPICE model (selected if aj<=0.0) and a smooth, single-piece
//  version (selected if aj>0). The basic normalized depletion capacitance is
//    cj(v)=1/(1-v/pj)^mj
//  and the normalized depletion charge qj(v) is the integral of this.
//
//  Outputs:
//    qj         junction depletion charge (normalized, so cj(0)=1)
//  Inputs:
//    v          voltage across the junction
//    pj         built-in voltage of the junction
//    mj         grading coefficient of the junction
//    fc         linearization factor, model is linearized for v>fc*pj
//    aj         smoothing parameter, if aj<=0 the model is regional
//    blockName  name for the begin/end block (must be unique)
//
//  There are 6 variants of the (aj>0) depletion charge model. Physically,
//  for high forward bias the depletion region does not exist as it is swamped by
//  mobile carriers, hence the depletion charge (and capacitance) should
//  go to zero. This gives a cj(v) characteristic that peaks and then drops
//  to zero as v increases. This characteristic can cause convergence problems
//  and has to be carefully matched with a diffusion charge model so that the
//  total (depletion+diffusion) charge and capacitance are modeled accurately.
//  A less radical version of this is provided, that smoothly approaches the
//  constant capacitance at v=fc*pj. This also needs to be carefully integrated
//  with a diffusion charge model to give correct total (depletion+diffusion)
//  charge and capacitance modeling. A smooth version of the standard SPICE
//  model, where the capacitance linearly increases with voltage for v>fc*pj,
//  is also provided. In the absence of a diffusion charge model, which is
//  often the case for parasitic junction models which are not expected to be
//  driven to high forward bias and so for which diffusion charge can be ignored,
//  the version that gives a linear cj(v) form for v>fc*pj should be used.
//
//  Each of these 3 models has 2 variants, one that has qj(v=0)=0 and another
//  that does not. For capacitance modeling it does not matter which is used,
//  as only the derivative is important. For modeling base-charge in BJTs
//  it is the change in depletion charge w.r.t. zero bias that is used to
//  model the Early effect, hence qj(v=0)=0 is required. This requires
//  additional calculations that are not needed if only capacitance modeling
//  is of interest. Hence versions that do not force qj(v=0)=0 are provided
//  as they are more efficient to evaluate.
//
//                         cj(v) for
//  Name       qj(v=0)=0   v->+inf
//  =========  ==========  ========
//  qj         no          linear in v
//  qj_z       yes         linear in v
//  qjCnst     no          constant 1/(1-fc)^mj
//  qjCnst_z   yes         constant 1/(1-fc)^mj
//  qjPeak     no          zero
//  qjPeak_z   yes         zero
//

`define qj(qj,v,pj,mj,fc,aj,blockName) \
begin : blockName \
    real dv0, dvh, pwq, qlo, qhi, mv0, vl0, dv, mv, vl; \
    dv0   = -(pj)*(fc); \
    if ((aj)<=0.0) begin \
        dvh =  (v)+dv0; \
        if (dvh>0.0) begin \
            pwq = pow((1.0-(fc)),(-(mj))); \
            qlo = (pj)*(1.0-pwq*(1.0-(fc)))/(1.0-(mj)); \
            qhi = dvh*(1.0+0.5*(mj)*dvh/((pj)*(1.0-(fc))))*pwq; \
        end else begin \
            qlo = (pj)*(1.0-pow((1.0-(v)/(pj)),(1.0-(mj))))/(1.0-(mj)); \
            qhi = 0.0; \
        end \
        qj  = qlo+qhi; \
    end else begin \
        mv0 =  sqrt(dv0*dv0+4.0*(aj)*(aj)); \
        vl0 = -0.5*(dv0+mv0); \
        dv  =  (v)+dv0; \
        mv  =  sqrt(dv*dv+4.0*(aj)*(aj)); \
        vl  =  0.5*(dv-mv)-dv0; \
        qlo = -(pj)*pow((1.0-vl/(pj)),(1.0-(mj)))/(1.0-(mj)); \
        qj  =  qlo+pow((1.0-(fc)),(-(mj)))*((v)-vl+vl0)*(1.0+0.5*(mj)*((v)-vl+vl0)/((pj)*(1.0-(fc)))); \
    end \
end

`define qj_z(qj,v,pj,mj,fc,aj,blockName) \
begin : blockName \
    real dv0, dvh, pwq, qlo, qhi, mv0, vl0, q0, dv, mv, vl; \
    dv0   = -(pj)*(fc); \
    if ((aj)<=0.0) begin \
        dvh =  (v)+dv0; \
        if (dvh>0.0) begin \
            pwq = pow((1.0-(fc)),(-(mj))); \
            qlo = (pj)*(1.0-pwq*(1.0-(fc)))/(1.0-(mj)); \
            qhi = dvh*(1.0+0.5*(mj)*dvh/((pj)*(1.0-(fc))))*pwq; \
        end else begin \
            qlo = (pj)*(1.0-pow((1.0-(v)/(pj)),(1.0-(mj))))/(1.0-(mj)); \
            qhi = 0.0; \
        end \
        qj  = qlo+qhi; \
    end else begin \
        mv0 =  sqrt(dv0*dv0+4.0*(aj)*(aj)); \
        vl0 = -0.5*(dv0+mv0); \
        q0  = -(pj)*pow((1.0-vl0/(pj)),(1.0-(mj)))/(1.0-(mj)); \
        dv  =  (v)+dv0; \
        mv  =  sqrt(dv*dv+4.0*(aj)*(aj)); \
        vl  =  0.5*(dv-mv)-dv0; \
        qlo = -(pj)*pow((1.0-vl/(pj)),(1.0-(mj)))/(1.0-(mj)); \
        qj  =  qlo+pow((1.0-(fc)),(-(mj)))*((v)-vl+vl0)*(1.0+0.5*(mj)*((v)-vl+vl0)/((pj)*(1.0-(fc))))-q0; \
    end \
end

`define qjCnst(qj,v,pj,mj,fc,aj,blockName) \
begin : blockName \
    real dv0, dvh, pwq, qlo, qhi, mv0, vl0, dv, mv, vl; \
    dv0   = -(pj)*(fc); \
    if ((aj)<=0.0) begin \
        dvh =  (v)+dv0; \
        if (dvh>0.0) begin \
            pwq = pow((1.0-(fc)),(-(mj))); \
            qlo = (pj)*(1.0-pwq*(1.0-(fc)))/(1.0-(mj)); \
            qhi = dvh*pwq; \
        end else begin \
            qlo = (pj)*(1.0-pow((1.0-(v)/(pj)),(1.0-(mj))))/(1.0-(mj)); \
            qhi = 0.0; \
        end \
        qj  = qlo+qhi; \
    end else begin \
        mv0 =  sqrt(dv0*dv0+4.0*(aj)*(aj)); \
        vl0 = -0.5*(dv0+mv0); \
        dv  =  (v)+dv0; \
        mv  =  sqrt(dv*dv+4.0*(aj)*(aj)); \
        vl  =  0.5*(dv-mv)-dv0; \
        qlo = -(pj)*pow((1.0-vl/(pj)),(1.0-(mj)))/(1.0-(mj)); \
        qj  =  qlo+pow((1.0-(fc)),(-(mj)))*((v)-vl+vl0); \
    end \
end

`define qjCnst_z(qj,v,pj,mj,fc,aj,blockName) \
begin : blockName \
    real dv0, dvh, pwq, qlo, qhi, mv0, vl0, q0, dv, mv, vl; \
    dv0   = -(pj)*(fc); \
    if ((aj)<=0.0) begin \
        dvh =  (v)+dv0; \
        if (dvh>0.0) begin \
            pwq = pow((1.0-(fc)),(-(mj))); \
            qlo = (pj)*(1.0-pwq*(1.0-(fc)))/(1.0-(mj)); \
            qhi = dvh*pwq; \
        end else begin \
            qlo = (pj)*(1.0-pow((1.0-(v)/(pj)),(1.0-(mj))))/(1.0-(mj)); \
            qhi = 0.0; \
        end \
        qj  = qlo+qhi; \
    end else begin \
        mv0 =  sqrt(dv0*dv0+4.0*(aj)*(aj)); \
        vl0 = -0.5*(dv0+mv0); \
        q0  = -(pj)*pow((1.0-vl0/(pj)),(1.0-(mj)))/(1.0-(mj)); \
        dv  =  (v)+dv0; \
        mv  =  sqrt(dv*dv+4.0*(aj)*(aj)); \
        vl  =  0.5*(dv-mv)-dv0; \
        qlo = -(pj)*pow((1.0-vl/(pj)),(1.0-(mj)))/(1.0-(mj)); \
        qj  =  qlo+pow((1.0-(fc)),(-(mj)))*((v)-vl+vl0)-q0; \
    end \
end

`define qjPeak(qj,v,pj,mj,fc,aj,blockName) \
begin : blockName \
    real dv0, dvh, pwq, qlo, dv, mv, vl; \
    dv0   = -(pj)*(fc); \
    if ((aj)<=0.0) begin \
        dvh =  (v)+dv0; \
        if (dvh>0.0) begin \
            pwq = pow((1.0-(fc)),(-(mj))); \
            qj  = (pj)*(1.0-pwq*(1.0-(fc)))/(1.0-(mj)); \
        end else begin \
            qj  = (pj)*(1.0-pow((1.0-(v)/(pj)),(1.0-(mj))))/(1.0-(mj)); \
        end \
    end else begin \
        dv  =  (v)+dv0; \
        mv  =  sqrt(dv*dv+4.0*(aj)*(aj)); \
        vl  =  0.5*(dv-mv)-dv0; \
        qj  = -(pj)*pow((1.0-vl/(pj)),(1.0-(mj)))/(1.0-(mj)); \
    end \
end

`define qjPeak_z(qj,v,pj,mj,fc,aj,blockName) \
begin : blockName \
    real dv0, dvh, pwq, mv0, vl0, q0, dv, mv, vl; \
    dv0   = -(pj)*(fc); \
    if ((aj)<=0.0) begin \
        dvh =  (v)+dv0; \
        if (dvh>0.0) begin \
            pwq = pow((1.0-(fc)),(-(mj))); \
            qj  = (pj)*(1.0-pwq*(1.0-(fc)))/(1.0-(mj)); \
        end else begin \
            qj  = (pj)*(1.0-pow((1.0-(v)/(pj)),(1.0-(mj))))/(1.0-(mj)); \
        end \
    end else begin \
        mv0 =  sqrt(dv0*dv0+4.0*(aj)*(aj)); \
        vl0 = -0.5*(dv0+mv0); \
        q0  = -(pj)*pow((1.0-vl0/(pj)),(1.0-(mj)))/(1.0-(mj)); \
        dv  =  (v)+dv0; \
        mv  =  sqrt(dv*dv+4.0*(aj)*(aj)); \
        vl  =  0.5*(dv-mv)-dv0; \
        qj  = -(pj)*pow((1.0-vl/(pj)),(1.0-(mj)))/(1.0-(mj))-q0; \
    end \
end

////////////////////////////////////////////////////////////////////////////////
////////////////////////////////////////////////////////////////////////////////
//
//  pn junction current, includes area and perimeter components
//
//  Outputs:
//    pnjI       junction current
//  Inputs:
//    v          voltage across the junction
//    phi_t      the thermal voltage
//    a          area of junction
//    isa        saturation current per unit area
//    na         ideality factor of the area component
//    vmaxa      linearization voltage for the area component
//    p          perimeter of junction
//    isp        saturation current per unit perimeter
//    np         ideality factor of the perimeter component
//    vmaxp      linearization voltage for the perimeter component
//    blockName  name for the begin/end block (must be unique)
//

`define pnjIap(pnjI,v,phi_t,a,isa,na,vmaxa,p,isp,np,vmaxp,blockName) \
begin : blockName \
    real aisa,pisp,argx,expx,pnjIa,pnjIp; \
    aisa     = (a)*(isa); \
    pisp     = (p)*(isp); \
    if (aisa>0.0) begin \
        argx     =  1.0/((na)*(phi_t)); \
        `expLinA(expx,v,vmaxa,argx)  \
        pnjIa    =  aisa*(expx-1.0); \
    end else begin \
        pnjIa    =  0.0; \
    end \
    if (pisp>0.0) begin \
        argx     =  1.0/((np)*(phi_t)); \
        `expLinA(expx,v,vmaxp,argx)  \
        pnjIp    =  pisp*(expx-1.0); \
    end else begin \
        pnjIp    =  0.0; \
    end \
    pnjI    =  pnjIa+pnjIp; \
end

////////////////////////////////////////////////////////////////////////////////
////////////////////////////////////////////////////////////////////////////////
//
//  pn junction depletion charge, includes area and perimeter components
//
//  Based on the basic depletion charge model with a linear increase
//  in c(v) at high forward bias, qj(v=0)=0 is not enforced.
//
//  Outputs:
//    pnjQ       junction charge
//  Inputs:
//    v          voltage across the junction
//    a          area of junction
//    cja        zero-bias capacitance per unit area
//    pja        built-in voltage of the area component
//    mja        grading coefficient of the area component
//    fca        linearization factor of the are component
//    aja        smoothing parameter of the area component
//    p          perimeter of junction
//    cjp        zero-bias capacitance per unit perimeter
//    pjp        built-in voltage of the perimeter component
//    mjp        grading coefficient of the perimeter component
//    fcp        linearization factor of the perimeter component
//    ajp        smoothing parameter of the perimeter component
//    blockName  name for the begin/end block (must be unique)
//    dba        name to pass to `qj for the area component (must be unique)
//    dbp        name to pass to `qj for the perimeter component (must be unique)
//

`define pnjQap(pnjQ,v,a,cja,pja,mja,fca,aja,p,cjp,pjp,mjp,fcp,ajp,blockName,dba,dbp) \
begin : blockName \
    real acja,pcjp,arga,argp; \
    acja     = (a)*(cja); \
    pcjp     = (p)*(cjp); \
    if (acja>0.0) begin \
        `qj(arga,v,pja,mja,fca,aja,dba) \
    end else begin \
        arga     = 0.0; \
    end \
    if (pcjp>0.0) begin \
        `qj(argp,v,pjp,mjp,fcp,ajp,dbp) \
    end else begin \
        argp     = 0.0; \
    end \
    pnjQ     = acja*arga+pcjp*argp; \
end

////////////////////////////////////////////////////////////////////////////////
////////////////////////////////////////////////////////////////////////////////
//
//  simple junction breakdown current model
//
//  Outputs:
//    bkdI       breakdown current
//  Inputs:
//    v          voltage across the junction
//    Ibv        current at Vbv
//    Vbv        breakdown voltage (defined at Ibv)
//    phi_t      the thermal voltage
//    nb         ideality factor of the breakdown exponential
//    vmax       linearization voltage
//    blockName  name for the begin/end block (must be unique)
//
//  This model is based on the simple exponential breakdown model
//  for SPICE diodes. The model has current -Ibv at voltage -Vbv,
//  and varies exponentially with voltage. The nb parameter controls
//  the steepness of the exponential. The current is linearized for
//  for high bias and has value zero at zero bias across the junction.
//

`define pnjIbkd(bkdI,v,Ibv,Vbv,phi_t,nb,vmax,blockName) \
begin : blockName \
    real Vbkd,argx,expx; \
    if ((Vbv)>0.0) begin \
        Vbkd     = -(Vbv)-(v); \
        argx     =  1.0/((nb)*(phi_t)); \
        `expLinA(expx,Vbkd,vmax,argx)  \
        bkdI     = -Ibv*(expx-exp(-(Vbv)*argx)); \
    end else begin \
        bkdI     =  0.0; \
    end \
end

////////////////////////////////////////////////////////////////////////////////
////////////////////////////////////////////////////////////////////////////////
//
//  Built-in potential temperature mapping (smoothly goes to zero for high T).
//
//  This is originally from Richard Booth (Agere Systems), and is physically
//  based on the built-in potential being
//    (kT/q)*ln(ppo*nno/ni^2)
//  whereas the standard SPICE model is based on
//    (kT/q)*ln(NA*ND/ni^2)
//  which assumes ppo=NA and nno=ND and does not take into account that at high
//  temperatures material becomes intrinsic and ppo and nno approach ni.
//  The model is based on
//    ni^2(T)=ni^2(Tnom)*exp(-(EA*q/k)*(1/T-1/Tnom))*(T/Tnom)^3
//  where the temperatures T and Tnom are in Kelvin.
//
//  A derivation is available at http://www.designers-guide.org/VBIC/documents/notesPsibi.html
//
//  Outputs:
//    psibi      built-in potential at temperature T
//  Inputs:
//    pjNom      built-in potential at reference temperature Tnom
//    ea         activation energy for intrinsic concentration squared
//    phi_t      thermal voltage at temperature T (=k*T/q)
//    rt         T/Tnom, ratio of temperatures
//    blockName  name for the begin/end block (must be unique)
//

`define psibi(psibi,pjNom,ea,phi_t,rt,blockName) \
begin : blockName \
    real psiio, psiin ; \
    psiio = 2.0*((phi_t)/(rt))*ln(exp(0.5*(pjNom)*(rt)/(phi_t))-exp(-0.5*(pjNom)*(rt)/(phi_t))); \
    psiin = psiio*(rt)-3.0*(phi_t)*ln((rt))-(ea)*((rt)-1.0); \
    psibi = psiin+2.0*(phi_t)*ln(0.5*(1.0+sqrt(1.0+4.0*exp(-psiin/(phi_t))))); \
end

////////////////////////////////////////////////////////////////////////////////
////////////////////////////////////////////////////////////////////////////////
//
//  Junction shot noise (including ideal and nonideal components of current)
//
//  The commonly used shot noise model 2q|I| is inaccurate for voltages less
//  than a few phi_t, and for pn junctions with nonideal components of current
//  can underpredict the noise. This formulation overcomes those limitations
//  and, for zero nonideal component, matches the van der Ziel result.
//
//  Inputs:
//    b_j        branch defined for the intrinsic pn junction
//    iSat       ideal saturation current
//    iIdeal     ideal component of current
//    iNonideal  nonideal component of current
//    label      string that identifies the noise component (must be in "")
//

`define pnjShotNoise(b_j,iSat,iIdeal,iNonideal,label) \
    I(b_j) <+ white_noise(2.0*`QQ_NIST2004*(abs(iIdeal+2.0*iSat)+abs(iNonideal)),label);
